** sch_path: /foss/designs/MMM-LAB DESIGN/OPAM/OPAM2.sch
**.subckt OPAM2 VDD INP OUT INN VSS
*.iopin VDD
*.ipin INN
*.iopin VSS
*.opin OUT
*.ipin INP
XM4 net2 INN net1 igzo_tft W=3200u L=25u ov=5u nf=1 m=1 B=0 b_scale=1
XM3 net3 INP net1 igzo_tft W=3200u L=25u ov=5u nf=1 m=1 B=0 b_scale=1
XM6 VDD VDD net2 igzo_tft W=50u L=200u ov=5u nf=1 m=1 B=0 b_scale=1
XM7 VDD VDD net3 igzo_tft W=50u L=200u ov=5u nf=1 m=1 B=0 b_scale=1
XM8 net1 net4 VSS igzo_tft W=200u L=200u ov=5u nf=1 m=1 B=0 b_scale=1
XM10 VDD net2 net4 igzo_tft W=200u L=200u ov=5u nf=1 m=1 B=0 b_scale=1
XM17 net5 net5 VSS igzo_tft W=200u L=100u ov=5u nf=1 m=1 B=0 b_scale=1
XM1 VDD net3 net4 igzo_tft W=200u L=200u ov=5u nf=1 m=1 B=0 b_scale=1
XM2 net4 net4 VSS igzo_tft W=140u L=200u ov=5u nf=1 m=1 B=0 b_scale=1
XM9 net6 net5 VSS igzo_tft W=200u L=200u ov=5u nf=1 m=1 B=0 b_scale=1
XM11 VDD net2 net5 igzo_tft W=50u L=800u ov=5u nf=1 m=1 B=0 b_scale=1
XM5 VDD net3 net6 igzo_tft W=50u L=800u ov=5u nf=1 m=1 B=0 b_scale=1
XM12 OUT net6 VSS igzo_tft W=1300u L=140u ov=5u nf=1 m=1 B=0 b_scale=1
XM13 VDD VDD OUT igzo_tft W=140u L=200u ov=5u nf=1 m=1 B=0 b_scale=1
**.ends
.end
