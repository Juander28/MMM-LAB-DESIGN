* ==========================================================================
* OPAM - unipolar a-IGZO amplifier with cross-coupled pair and capacitor
* bootstrap load.  Topology after Zhao et al., IEEE TBCAS 18(6), 2024;
* device names follow MMM-LAB DESIGN/OPAM/OPAM.sch, not the paper's.
*
* GENERATED by sim/make_core.py from OPAM.sch - do not edit by hand.  Node
* names come from the schematic, so the two cannot disagree.
*
* Signal path:
*   INP/INN -> differential pair XM2/XM5, in parallel with the cross-coupled
*   pair XM3/XM4 (gate of one on the drain of the other: a negative
*   conductance that partly cancels the diode loads XM6/XM7)
*   -> the right branch XM18 -> bootstrap load XM19/XM20 + C2 -> follower
*   XM16 -> OUT, diode load XM15.  The left branch is the matched replica.
*
* BOOT_L / BOOT_R are the bootstrap gate nodes.  Level 1 has no subthreshold
* current, so XM14/XM20 leak exactly nothing and those nodes would have no DC
* path at all; Rb1/Rb2 stand in for the off-state channel and make the
* operating point a stated assumption instead of whatever the solver picks.
* At DC that leaves XM13/XM19 gate-tied to VDD - a diode load - while above
* the corner set by C1/C2 the capacitor holds their Vgs constant and they
* become current sources.  That is the trick of the paper.
* ==========================================================================

.param r_off = 1e12   $ off-state channel resistance of XM14 / XM20
* Magnetic field, forwarded to every device so a sweep is a one-line change.
* The wrapper divides the intrinsic W by 1 + (mu*b_scale*B)^2, which - since
* level 1 only ever uses the product Kp*W/L - is the same as dividing Kp, i.e.
* the same as dividing the mobility.  That IS classical magnetoresistance;
* Kn and channel resistance are one fact, not two.  Contact resistance and
* overlap capacitance use the outer W and do not move with the field, which is
* where the physics leaves them too.
*
* b_gain is the hook for a measured effect: 1 means classical, and classical
* here is (mu*B)^2 = 2e-7 per tesla, which is not a sensor.
.param b_field = 0
.param b_gain  = 1
.subckt OPAM VDD OUT INN INP VSS
XM2   net2    INP     net1    igzo_tft W='w_in' L='l_in' ov=5u nf=1 B='b_field' b_scale='b_gain'
XM4   net2    net3    net1    igzo_tft W='w_cc' L='l_cc' ov=5u nf=1 B='b_field' b_scale='b_gain'
XM3   net3    net2    net1    igzo_tft W='w_cc' L='l_cc' ov=5u nf=1 B='b_field' b_scale='b_gain'
XM5   net3    INN     net1    igzo_tft W='w_in' L='l_in' ov=5u nf=1 B='b_field' b_scale='b_gain'
XM6   VDD     VDD     net2    igzo_tft W='w_dl' L='l_dl' ov=5u nf=1 B='b_field' b_scale='b_gain'
XM7   VDD     VDD     net3    igzo_tft W='w_dl' L='l_dl' ov=5u nf=1 B='b_field' b_scale='b_gain'
XM8   net1    BIAS    VSS     igzo_tft W='w_tail' L='l_tail' ov=5u nf=1 B='b_field' b_scale='b_gain'
XM9   net5    net5    VSS     igzo_tft W='w_od' L='l_od' ov=5u nf=1 B='b_field' b_scale='b_gain'
XM10  VDD     net4    net5    igzo_tft W='w_of' L='l_of' ov=5u nf=1 B='b_field' b_scale='b_gain'
XM11  net6    BIAS    VSS     igzo_tft W='w_t2' L='l_t2' ov=5u nf=1 B='b_field' b_scale='b_gain'
XM12  net4    net2    net6    igzo_tft W='w_g2' L='l_g2' ov=5u nf=1 B='b_field' b_scale='b_gain'
XM13  VDD     BOOT_L  net4    igzo_tft W='w_bl' L='l_bl' ov=5u nf=1 B='b_field' b_scale='b_gain'
XM14  VDD     net4    BOOT_L  igzo_tft W='w_bf' L='l_bf' ov=5u nf=1 B='b_field' b_scale='b_gain'
XC1   BOOT_L  net4    cap_mim W='c_boot' L='c_boot'
XM15  OUT     OUT     VSS     igzo_tft W='w_od' L='l_od' ov=5u nf=1 B='b_field' b_scale='b_gain'
XM16  VDD     net7    OUT     igzo_tft W='w_of' L='l_of' ov=5u nf=1 B='b_field' b_scale='b_gain'
XM17  net8    BIAS    VSS     igzo_tft W='w_t2' L='l_t2' ov=5u nf=1 B='b_field' b_scale='b_gain'
XM18  net7    net3    net8    igzo_tft W='w_g2' L='l_g2' ov=5u nf=1 B='b_field' b_scale='b_gain'
XM19  VDD     BOOT_R  net7    igzo_tft W='w_bl' L='l_bl' ov=5u nf=1 B='b_field' b_scale='b_gain'
XM20  VDD     net7    BOOT_R  igzo_tft W='w_bf' L='l_bf' ov=5u nf=1 B='b_field' b_scale='b_gain'
XC2   BOOT_R  net7    cap_mim W='c_boot' L='c_boot'
XC3   INN     net2    cap_mim W='c_fb' L='c_fb'
XC4   net3    INP     cap_mim W='c_fb' L='c_fb'
Rb1   BOOT_L  VDD     'r_off'
Rb2   BOOT_R  VDD     'r_off'

* --- on-chip bias reference: BIAS is generated here, not brought in on a pin -
* Three diode-connected devices from VDD to VSS.  The tap sits two gate-source
* drops above VSS, and a gate-source drop is Vth + Vov, so BIAS follows Vth on
* its own - which is exactly the per-corner trim that used to be applied by
* hand.  The top of the chain is split in two so no device sees more than
* about half the supply across its gate: a single top device would sit at
* Vgs = 6.7 V, outside the range the models are validated for.
XMB1  net_b1  net_b1  BIAS    igzo_tft W='w_b1' L='l_b1' ov=5u nf=1 B='b_field' b_scale='b_gain'
XMB0  VDD     VDD     net_b1  igzo_tft W='w_b1' L='l_b1' ov=5u nf=1 B='b_field' b_scale='b_gain'
XMB2  BIAS    BIAS    VSS     igzo_tft W='w_b2' L='l_b2' ov=5u nf=1 B='b_field' b_scale='b_gain'

.ends OPAM
