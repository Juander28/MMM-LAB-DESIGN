* ==========================================================================
* OPAM2 open-loop gain testbench - final sizing
*
* Run it with:   ngspice -b tb_opam2.spice
* Change the corner on the .lib line below (best / tt / all).
*
* The IGZO models are DC-only, so the number reported here is the DC gain:
* the AC sweep starts at 0.1 Hz and the gain is read in the flat region.
* The input sweep stays inside the validated box (VGS <= 6 V, VDS <= 10 V).
* ==========================================================================

.include "/foss/designs/TFT-MMM-LAB-PDK/libs.tech/ngspice/design.ngspice"
.lib /foss/designs/TFT-MMM-LAB-PDK/libs.tech/ngspice/igzo_mmm_lab.ngspice best

.include "opam2_core.spice"

.param vdd = 8
.param vcm = 3.2
.param l_cmd   = 200u
.param l_cms   = 200u
.param l_d2s   = 200u
.param l_dl    = 200u
.param l_in    = 25u
.param l_od    = 140u
.param l_ol    = 200u
.param l_sf    = 800u
.param l_sfl   = 100u
.param l_tail  = 200u
.param w_cmd   = 140u
.param w_cms   = 200u
.param w_d2s   = 200u
.param w_dl    = 50u
.param w_in    = 3200u
.param w_od    = 1300u
.param w_ol    = 140u
.param w_sf    = 50u
.param w_sfl   = 200u
.param w_tail  = 200u

* --- sizing found by optimize.py, scored at the worst of best/tt/all -------

VDD VDD 0 DC 'vdd'
VCM cm  0 DC 'vcm'
VD  d   0 DC 0 AC 1 SIN(0 0.005 1)
EIP INP cm d 0 0.5
EIN INN cm d 0 -0.5

x1 VDD INP OUT INN 0 OPAM2

.control
set filetype=ascii
save all

* --- 1. operating point ----------------------------------------------------
op
echo === operating point ===
print v(OUT) v(x1.net1) v(x1.net2) v(x1.net3) v(x1.net4) v(x1.net5) v(x1.net6)
print i(VDD)
show m : vgs vds id gm gds

* --- 2. Bode: magnitude and phase ------------------------------------------
ac dec 20 0.1 1e6
let mag_db = vdb(OUT)
let phase  = 180/PI * cph(v(OUT))
* The reference is the PEAK of the response, not the value at 0.1 Hz.  OPAM
* rises about 2 dB from 0.1 Hz to a peak near 2 Hz, so reading the gain at the
* bottom of the sweep understates it and puts f-3dB in the wrong place.
meas ac av_dc  FIND vdb(OUT) AT=0.1
meas ac av_max MAX vdb(OUT)
meas ac f3db   WHEN vdb(OUT)='av_max-3' FALL=1
meas ac funity WHEN vdb(OUT)=0 FALL=1
* Phase margin against the DC phase, not against zero: an inverting amplifier
* already sits at 180 degrees at DC, and subtracting it is what makes the
* number mean the same thing for both circuits.
meas ac ph_dc FIND phase AT=0.1
meas ac ph_u  FIND phase WHEN vdb(OUT)=0 FALL=1
let pm = 180 + (ph_u - ph_dc)
echo === bode: gain, corner, unity gain, phase margin ===
print av_dc av_max f3db funity ph_dc ph_u pm
* the AC vectors die with the plot, so keep what the later runs need
set avmaxs = $&av_max
set f3s    = $&f3db

* --- 3. input / output relation --------------------------------------------
dc VD -2 2 0.01
echo === transfer: output against differential input ===
meas dc out_max MAX v(OUT)
meas dc out_min MIN v(OUT)
meas dc vo_0    FIND v(OUT) AT=0
meas dc vo_p    FIND v(OUT) AT=0.01
meas dc vo_m    FIND v(OUT) AT=-0.01
let slope    = (vo_p - vo_m) / 0.02
let slope_db = db(abs(slope))
print out_max out_min vo_0 slope slope_db

* --- 4. sine inside the band -----------------------------------------------
* a decade below the corner, and small enough that the output cannot clip
let fsig = $f3s / 10
let amp  = 0.3 / (10^($avmaxs/20))
set fsigs = $&fsig
set amps  = $&amp
echo === sine: frequency and amplitude derived from the AC run ===
print fsig amp
* the honest reference for the cross-check is the AC gain at THIS frequency,
* not the flat-band figure - one extra single-point AC run buys that
ac lin 1 $fsigs $fsigs
let av_ref = vdb(OUT)
set avrefs = $&av_ref
alter VD sin = [ 0 $amps $fsigs ]
* Settle for 200 cycles before measuring, and step at 50 points per cycle.
* This is not caution for its own sake: OPAM's bootstrap gate node is held
* only by the off-device leakage (r_off in opam_core.spice), so the signal
* pumps charge into it through C2 and the node drifts for tens of seconds
* before it finds equilibrium.  Measured over 12 cycles the gain reads several
* dB high and is still moving; by 150 cycles it has converged and stays put
* through 1000.  OPAM2 has no such node and settles at once, so the same
* window costs it only simulation time.
let tskip = 200 / $fsigs
let tstop = tskip + 6 / $fsigs
set ts = $&tstop
set tk = $&tskip
let tstep = 1 / (50 * $fsigs)
set tstp = $&tstep
tran $tstp $ts $tk
echo === sine: measured input and output ===
meas tran vi_pp PP v(d)   FROM=$tk TO=$ts
meas tran vo_pp PP v(OUT) FROM=$tk TO=$ts
let av_tran = db(vo_pp / vi_pp)
print vi_pp vo_pp av_tran

* --- 5. the two gains have to agree ----------------------------------------
* A gap here is a result, not a glitch.  The AC run linearises about the DC
* operating point; the transient is the circuit actually running.  If they
* disagree by more than about 1 dB, either the sine is clipping or the
* operating point moves once the signal is applied - and for a floating
* bootstrap node, it does.
let gain_err = av_tran - $avrefs
print gain_err
echo === done ===
.endc

.end
