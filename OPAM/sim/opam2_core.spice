* ==========================================================================
* OPAM2 - all-enhancement IGZO TFT operational amplifier
* Topology after Zysset et al., IEEE EDL 34(11), 2013; device names follow
* MMM-LAB DESIGN/OPAM/OPAM2.sch, not the paper's numbering.
*
* GENERATED by sim/make_core.py from OPAM2.sch - do not edit by hand.
*
* Devices that must match share a parameter on purpose: the input pair, the
* two diode loads, the two common-mode sensing followers, and the two
* differential-to-single-ended followers.
*
* Multiplier m is folded into W: two devices of width W in parallel are
* exactly one device of width 2W in this wrapper (Rc goes as 1/W, Cov as W).
* ==========================================================================

* Magnetic field, forwarded to every device so a sweep is a one-line change.
* The wrapper divides the intrinsic W by 1 + (mu*b_scale*B)^2, which - since
* level 1 only ever uses the product Kp*W/L - is the same as dividing Kp, i.e.
* the same as dividing the mobility.  That IS classical magnetoresistance;
* Kn and channel resistance are one fact, not two.  Contact resistance and
* overlap capacitance use the outer W and do not move with the field, which is
* where the physics leaves them too.
*
* b_gain is the hook for a measured effect: 1 means classical, and classical
* here is (mu*B)^2 = 2e-7 per tesla, which is not a sensor.
.param b_field = 0
.param b_gain  = 1
.subckt OPAM2 VDD INP OUT INN VSS
XM4   net2    INN     net1    igzo_tft W='w_in' L='l_in' ov=5u nf=1 B='b_field' b_scale='b_gain'
XM3   net3    INP     net1    igzo_tft W='w_in' L='l_in' ov=5u nf=1 B='b_field' b_scale='b_gain'
XM6   VDD     VDD     net2    igzo_tft W='w_dl' L='l_dl' ov=5u nf=1 B='b_field' b_scale='b_gain'
XM7   VDD     VDD     net3    igzo_tft W='w_dl' L='l_dl' ov=5u nf=1 B='b_field' b_scale='b_gain'
XM8   net1    net4    VSS     igzo_tft W='w_tail' L='l_tail' ov=5u nf=1 B='b_field' b_scale='b_gain'
XM10  VDD     net2    net4    igzo_tft W='w_cms' L='l_cms' ov=5u nf=1 B='b_field' b_scale='b_gain'
XM17  net5    net5    VSS     igzo_tft W='w_sfl' L='l_sfl' ov=5u nf=1 B='b_field' b_scale='b_gain'
XM1   VDD     net3    net4    igzo_tft W='w_cms' L='l_cms' ov=5u nf=1 B='b_field' b_scale='b_gain'
XM2   net4    net4    VSS     igzo_tft W='w_cmd' L='l_cmd' ov=5u nf=1 B='b_field' b_scale='b_gain'
XM9   net6    net5    VSS     igzo_tft W='w_d2s' L='l_d2s' ov=5u nf=1 B='b_field' b_scale='b_gain'
XM11  VDD     net2    net5    igzo_tft W='w_sf' L='l_sf' ov=5u nf=1 B='b_field' b_scale='b_gain'
XM5   VDD     net3    net6    igzo_tft W='w_sf' L='l_sf' ov=5u nf=1 B='b_field' b_scale='b_gain'
XM12  OUT     net6    VSS     igzo_tft W='w_od' L='l_od' ov=5u nf=1 B='b_field' b_scale='b_gain'
XM13  VDD     VDD     OUT     igzo_tft W='w_ol' L='l_ol' ov=5u nf=1 B='b_field' b_scale='b_gain'

.ends OPAM2
