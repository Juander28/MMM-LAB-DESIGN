* ==========================================================================
* WPT link - IGZO TFT voltage doubler on a 1000 x 1000 um planar coil
*
* GENERATED by sim/wpt_core_gen.py from rx_coil.json, tx_coil.json and
* rectifier.json.  Every value here was chosen by a sweep; none was typed.
*
* Run it:   ngspice -b wpt_core.spice
*
* The transient starts from .ic v(out) = the steady state, because the output
* capacitor is 10 uF against a 10000 ohm load - a 0.1 s time constant
* against a 2e-06 s carrier period.  Simulating the charge-up honestly
* would take 5e+04 cycles.  The steady state does not depend on the
* capacitor, only the ripple and the settling do, so it is found on a small
* capacitor and confirmed here.  See tb_wpt.steady_state().
*
* WHAT IT REPORTS: 0.801 V into the load for 858 W at the driver,
* which is an efficiency of 7.49e-08.  Read the report before quoting that
* as a working link - it is four decades below anything useful, and the
* reason is the receive coil's Q of 0.0064, not the rectifier.
* ==========================================================================
.include /foss/designs/TFT-MMM-LAB-PDK/libs.tech/ngspice/design.ngspice
.lib /foss/designs/TFT-MMM-LAB-PDK/libs.tech/ngspice/igzo_mmm_lab.ngspice all

.param f      = 500000.0
.param vamp   = 152.1448678930087
.param rsrc   = 1.0
.param rload  = 10000.0
.param cres   = 1e-05
.param cout   = 1e-05
.param ctx    = 5.908554249866618e-10
.param cprx   = 1e-18
.param ccpl   = 1e-18
.param wtft   = 0.006
.param ltft   = 4.9999999999999996e-06
.param ovtft  = 2e-06

* ---- transmitter -------------------------------------------------------
V1   src 0   DC 0 AC 1 SIN(0 'vamp' 'f')
RSRC src txa 'rsrc'
CTX  txa tx1 'ctx'          $ series tuning of the transmit loop; 1F = short

* ---- the two coils and their coupling ----------------------------------
LTX  tx1 tx2 0.00017148219235631974
RTX  tx2 0   10.574030413090533
LRX  rx1 rx2 1.0128710367347827e-06
RRX  rx2 0   497.36960000000005
K1   LTX LRX 0.003584017879261674

* ---- receive side: DC block, rectifier, load ---------------------------
CRES rx1 n1  'cres'         $ the doubler's DC block
CPRX rx1 0   'cprx'         $ shunt across the receive coil; 1aF = open
CCPL n1  0   'ccpl'         $ the coupling-capacitor experiment; 1aF = open
XM1  0   0   n1  igzo_tft W='wtft' L='ltft' ov='ovtft' nf=1
XM2  n1  n1  out igzo_tft W='wtft' L='ltft' ov='ovtft' nf=1
COUT out 0   'cout'
RL   out 0   'rload'

.ic v(out)=0.801314
.control
set filetype=ascii
op
echo "--- AC: where the link peaks ---"
ac dec 40 1e3 1e7
let vrx = mag(v(rx1))
meas ac vrx_max MAX vrx
meas ac vrx_at  FIND vrx AT=500000.0
echo "--- transient: the steady state ---"
tran 1e-08 8.4e-05 0 1e-08
let pin  = -v(src)*i(V1)
let pout = v(out)*v(out)/10000.0
meas tran pin_avg  AVG pin  from=3.9999999999999996e-05 to=7.999999999999999e-05
meas tran pout_avg AVG pout from=3.9999999999999996e-05 to=7.999999999999999e-05
meas tran vout_avg AVG v(out) from=3.9999999999999996e-05 to=7.999999999999999e-05
meas tran vout_max MAX v(out) from=3.9999999999999996e-05 to=7.999999999999999e-05
meas tran vout_min MIN v(out) from=3.9999999999999996e-05 to=7.999999999999999e-05
let eff = pout_avg/pin_avg
print eff
.endc

.end
